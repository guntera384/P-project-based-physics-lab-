Transmission line
* This file was refactored by Claude 5.5.
* Defaults only; coax.py overrides them with alterparam.
* The analyses and .end are appended by coax.py.
.param zl=50
.param intres=0.05
.param pulseamp=1.2
.param td=1u

* Source: sine (also the AC stimulus) in series with a pulse. coax.py zeroes
* whichever amplitude is not wanted, which replaces the old .IF/.ELSE.
Vpul 1 0 PULSE(0 {pulseamp} {td} 1n 1n 10m)

r1 1 2 50                ; source resistance
r55 2 0 1meg             ; oscilloscope input

t50 2 0 3 0 z0=50 td=0.014us ; Initial cable
t3 3 0 4 0 z0=50 td=0.722us ; Cable 3
t1 4 0 5 0 z0=50 td=0.283us ; Cable 1
t2 4 0 6 0 z0=75 td=0.559us ; Cable 2

r10 6 0 0

.tran 0.001u 5u
.plot tran v(2)
