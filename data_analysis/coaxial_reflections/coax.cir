.title Transmission line
.param zl=50
.param intres=50
.param maxv=1
.param pulse=0
.IF(pulse == 1)
v1 1 0 pulse(-1 maxv 0 0 0 1u)
.ELSE
V1 1 0 DC 0 AC 1 $ SIN(0, maxv, 1k) Actual source
V23 23 0 SIN(0, maxv, 1k) $ for comparison
.ENDIF
r55 2 0 1000000 $ Oscilloscope
r1 1 2 50 $ Entrance voltage
o1 2 0 4 0 LOSSYMOD
.model LOSSYMOD ltra r=0.05 l=0.38u c=67p len=50 $ Coax
r2 4 0 r=zl
.ac dec 10 1 300000000
.PLOT ac vp(2,23)
.tran 50us 2000us
.PLOT tran v(2)
.end
